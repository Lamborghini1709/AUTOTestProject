; Haisi HBT Case:HBT_simple_1T （va）

; Options
Options:Options1  V_RelTol=1e-6 I_RelTol=1e-6 V_AbsTol=1e-6 I_AbsTol=1e-12  Temp=25 Tnom=25 Gmin=1e-12  ASCII_Rawfile=yes NumDigitsInRawfile=14  TopDesignName="2020326forSunjie_lib:HBT_simple_1T_builtin:schematic"

; Parameters
Pavs=0
Rfreq=1.0

; Models
simulator lang=spectre
global 0
include "../model/btd_hbt.1.modelcard"
simulator lang=ads

; Circuit
Short:DC_Block1 N__12 N__0 Mode=1
Short:Iinput Vinput N__12 Mode=0 SaveCurrent=yes
Short:Ioad N__14 Vload Mode=0 SaveCurrent=yes
Short:DC_Feed1 N__15 N__0 Mode=-1
Short:Icc Vcc N__2 Mode=0 SaveCurrent=yes
Short:DC_Block2 N__21 N__14 Mode=1
Short:Icc1 Vb N__15 Mode=0 SaveCurrent=yes
Short:DC_Feed2 N__2 N__17 Mode=-1

"HBTM1":HBT1 N__17 N__0 0 N__3 Mode=1 Noise=yes SelfTmod=0

Port:PORT1 Vinput 0 Num=1 Z=50 Ohm Noise=yes P[1]=dbmtow(Pavs) Freq[1]=Rfreq GHz  Pac=polar(dbmtow(0),0)
Port:Term2 Vload 0 Num=2 Z=50 Ohm Noise=yes

V_Source:SRC2 Vcc 0 Type="V_DC" Vdc=5 V SaveCurrent=1
V_Source:SRC3 Vb 0 Type="V_DC" Vdc=1.32 V SaveCurrent=1

CAPQ:C2 N__17 0 C=1.1 pF opt{ 0.1 pF to 10 pF } Q=50.0 F=1000.0 MHz Mode=1

#uselib "ckt" , "INDQ_Z"
INDQ_Z:L2 N__21 N__17 L=15 nH opt{ 0.01 nH to 10 nH } Q=50.0 F=1000.0 MHz Mode=1 Rdc=0.0 Ohm

Component Module="LinearCollapse" Type="ModelExtractor" NetworkRepresentation=2

S_Param:SP1  CalcS=yes CalcY=no CalcZ=no  GroupDelayAperture=1e-4 FreqConversion=no  FreqConversionPort=1 StatusLevel=2  CalcNoise=no SortNoise=0  BandwidthForNoise=1.0 Hz
 DevOpPtLevel=0  SweepVar="freq" SweepPlan="SP1_stim" OutputPlan="SP1_Output"

SweepPlan: SP1_stim Start=1.0 GHz Stop=10.0 GHz Step=0.1 GHz

OutputPlan:SP1_Output Type="Output" UseEquationNestLevel=yes EquationNestLevel=2 UseSavedEquationNestLevel=yes SavedEquationNestLevel=2

HB:HB2  MaxOrder=4 Freq[1]=Rfreq GHz Order[1]=5  StatusLevel=2 Restart=no CalcS_Params=yes  LSSP_FreqAtPort[1]=Rfreq GHz  LSSP_FreqAtPort[2]=Rfreq GHz  SweepVar="Rfreq" SweepPlan="HB2_stim" OutputPlan="HB2_Output"

SweepPlan: HB2_stim Start=1 Stop=10 Step=0.1

OutputPlan: HB2_Output Type="Output" UseEquationNestLevel=yes EquationNestLevel=2 UseSavedEquationNestLevel=yes SavedEquationNestLevel=2
